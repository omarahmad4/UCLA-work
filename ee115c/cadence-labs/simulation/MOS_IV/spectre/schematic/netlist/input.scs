// Design: ee115c/MOS_IV
simulator lang=spectre
global 0
parameters VDS=0.5 VGS=0.2
include "/usr/public.2/ee115c/cadence-labs/gpdk090_v3.4/models/spectre/gpdk090.scs" section=NN

// ee115c/MOS_IV/schematic
NM0 (net08 net5 net1 net1) gpdk090_nmos1v w=(240n) l=100n m=(1)*(1) simM=(1)*(1)
PM0 (net1 net6 net04 net04) gpdk090_pmos1v w=(480n) l=100n m=(1)*(1) simM=(1)*(1)
V6 (net3 net04) vsource dc=0 type=dc
V5 (net3 net08) vsource dc=0 type=dc
V3 (net3 net1) vsource dc=VDS type=dc
V2 (net5 net1) vsource dc=VGS type=dc
V1 (net3 net6) vsource dc=VGS type=dc
simulatorOptions options temp=27
dc dc param=VDS start=0 stop=1 step=0.05
save V5:p V6:p
