// Design: Proj/project1
simulator lang=spectre
global 0 vdd!
include "/usr/public.2/ee115c/cadence-labs/gpdk090_v3.4/models/spectre/gpdk090.scs" section=NN

// gsclib090/XOR2X1/schematic
subckt XOR2X1 A B Y inh_VDD inh_VSS
    mp3 (n0 n2 net130 inh_VDD) gpdk090_pmos1v w=(360n) l=100n m=(1)*(1) simM=(1)*(1)
    mp1 (n2 B inh_VDD inh_VDD) gpdk090_pmos1v w=(360n) l=100n m=(1)*(1) simM=(1)*(1)
    mp4 (n1 B n0 inh_VDD) gpdk090_pmos1v w=(360n) l=100n m=(1)*(1) simM=(1)*(1)
    mp0 (n1 A inh_VDD inh_VDD) gpdk090_pmos1v w=(360n) l=100n m=(1)*(1) simM=(1)*(1)
    mp5 (Y n0 inh_VDD inh_VDD) gpdk090_pmos1v w=(650n) l=100n m=(1)*(1) simM=(1)*(1)
    mp2 (net130 n1 inh_VDD inh_VDD) gpdk090_pmos1v w=(360n) l=100n m=(1)*(1) simM=(1)*(1)
    mn1 (n2 B inh_VSS inh_VSS) gpdk090_nmos1v w=(240n) l=100n m=(1)*(1) simM=(1)*(1)
    mn0 (n1 A inh_VSS inh_VSS) gpdk090_nmos1v w=(240n) l=100n m=(1)*(1) simM=(1)*(1)
    mn5 (Y n0 inh_VSS inh_VSS) gpdk090_nmos1v w=(430n) l=100n m=(1)*(1) simM=(1)*(1)
    mn3 (n0 B net131 inh_VSS) gpdk090_nmos1v w=(240n) l=100n m=(1)*(1) simM=(1)*(1)
    mn4 (n0 n2 n1 inh_VSS) gpdk090_nmos1v w=(240n) l=100n m=(1)*(1) simM=(1)*(1)
    mn2 (net131 n1 inh_VSS inh_VSS) gpdk090_nmos1v w=(240n) l=100n m=(1)*(1) simM=(1)*(1)
ends XOR2X1

// gsclib090/NAND2X1/schematic
subckt NAND2X1 A B Y inh_VDD inh_VSS
    mp1 (Y B inh_VDD inh_VDD) gpdk090_pmos1v w=(650n) l=100n m=(1)*(1) simM=(1)*(1)
    mp0 (Y A inh_VDD inh_VDD) gpdk090_pmos1v w=(650n) l=100n m=(1)*(1) simM=(1)*(1)
    mn1 (Y B n0 inh_VSS) gpdk090_nmos1v w=(430n) l=100n m=(1)*(1) simM=(1)*(1)
    mn0 (n0 A inh_VSS inh_VSS) gpdk090_nmos1v w=(430n) l=100n m=(1)*(1) simM=(1)*(1)
ends NAND2X1

// gsclib090/NOR2X1/schematic
subckt NOR2X1 A B Y inh_VDD inh_VSS
    mp1 (Y B net41 inh_VDD) gpdk090_pmos1v w=(650n) l=100n m=(1)*(1) simM=(1)*(1)
    mp0 (net41 A inh_VDD inh_VDD) gpdk090_pmos1v w=(650n) l=100n m=(1)*(1) simM=(1)*(1)
    mn1 (Y B inh_VSS inh_VSS) gpdk090_nmos1v w=(430n) l=100n m=(1)*(1) simM=(1)*(1)
    mn0 (Y A inh_VSS inh_VSS) gpdk090_nmos1v w=(430n) l=100n m=(1)*(1) simM=(1)*(1)
ends NOR2X1

// gsclib090/INVX1/schematic
subckt INVX1 A Y inh_VDD inh_VSS
    mp0 (Y A inh_VDD inh_VDD) gpdk090_pmos1v w=(650n) l=100n m=(1)*(1) simM=(1)*(1)
    mn0 (Y A inh_VSS inh_VSS) gpdk090_nmos1v w=(430n) l=100n m=(1)*(1) simM=(1)*(1)
ends INVX1

// Proj/project1/schematic
I4 (net22 vdd! net68 vdd! 0) XOR2X1
I3 (X1 net26 net67 vdd! 0) XOR2X1
I2 (net23 net25 net71 vdd! 0) XOR2X1
I1 (X3 net24 net69 vdd! 0) XOR2X1
I0 (net66 net40 net70 vdd! 0) XOR2X1
I27 (net62 net83 M0 vdd! 0) NAND2X1
I26 (net63 net76 M1 vdd! 0) NAND2X1
I25 (net64 net78 M2 vdd! 0) NAND2X1
I24 (net65 net80 M3 vdd! 0) NAND2X1
I23 (net60 net61 M4 vdd! 0) NAND2X1
I22 (X0 net16 net62 vdd! 0) NAND2X1
I21 (X1 net16 net63 vdd! 0) NAND2X1
I20 (X2 net16 net64 vdd! 0) NAND2X1
I19 (X3 net16 net65 vdd! 0) NAND2X1
I18 (X4 net16 net60 vdd! 0) NAND2X1
I16 (net68 X5 net83 vdd! 0) NAND2X1
I15 (net67 X5 net76 vdd! 0) NAND2X1
I14 (net71 X5 net78 vdd! 0) NAND2X1
I13 (net69 X5 net80 vdd! 0) NAND2X1
I12 (net70 X5 net61 vdd! 0) NAND2X1
I6 (net23 net25 net24 vdd! 0) NAND2X1
I5 (net22 vdd! net26 vdd! 0) NAND2X1
I8 (X3 net24 net40 vdd! 0) NOR2X1
I7 (X1 net26 net25 vdd! 0) NOR2X1
I17 (X5 net16 vdd! 0) INVX1
I11 (X4 net66 vdd! 0) INVX1
I10 (X2 net23 vdd! 0) INVX1
I9 (X0 net22 vdd! 0) INVX1
include "./_graphical_stimuli.scs"
simulatorOptions options temp=27
