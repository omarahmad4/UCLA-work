// Design: ee115c/FO4-inv
simulator lang=spectre
global 0 vddd! vdd!
parameters VD=1.0
include "/usr/public.2/ee115c/cadence-labs/gpdk090_v3.4/models/spectre/gpdk090.scs" section=NN

// ee115c/INVX1/schematic
subckt INVX1 A GND VDD Z
    NM0 (Z A GND GND) gpdk090_nmos1v w=(240n) l=100n m=(1)*(1) simM=(1)*(1)
    PM0 (Z A VDD VDD) gpdk090_pmos1v w=(480n) l=100n m=(1)*(1) simM=(1)*(1)
ends INVX1

// ee115c/FO4_inv_stage/schematic
subckt FO4_inv_stage A GND VDD VGOLD Z
    I3 (A GND VGOLD net24) INVX1
    I2 (A GND VGOLD net22) INVX1
    I1 (A GND VGOLD net20) INVX1
    I0 (A GND VDD Z) INVX1
    C2 (net24 GND) capacitor c=100f
    C1 (net22 GND) capacitor c=100f
    C0 (net20 GND) capacitor c=100f
ends FO4_inv_stage

// ee115c/FO4-inv/schematic
V0 (net5 0) vsource type=pulse val0=0 val1=VD period=400p delay=100p rise=10p fall=10p width=200p
C0 (net4 0) capacitor c=100f
I6 (out 0 vdd! vddd! net4) FO4_inv_stage
I5 (in 0 vdd! vddd! out) FO4_inv_stage
I4 (net5 0 vdd! vddd! in) FO4_inv_stage
include "./_graphical_stimuli.scs"
simulatorOptions options temp=27
tran tran stop=1n errpreset=moderate
