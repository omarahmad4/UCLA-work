// Design: ee115c/hw2_NMOS
simulator lang=spectre
global 0
parameters VGS=0.4 VSB=0 VDS=0
include "/usr/public.2/ee115c/cadence-labs/gpdk090_v3.4/models/spectre/gpdk090.scs" section=NN

// ee115c/hw2_NMOS/schematic
NM0 (net4 net3 net1 net06) gpdk090_nmos1v w=(240n) l=100n m=(1)*(1) simM=(1)*(1)
V3 (net06 net1) vsource dc=VSB type=dc
V2 (net5 net4) vsource dc=0 type=dc
V1 (net5 net1) vsource dc=VDS type=dc
V0 (net3 net1) vsource dc=VGS type=dc
simulatorOptions options temp=27
dc dc param=VDS start=0 stop=1 step=0.05
save V2:p
