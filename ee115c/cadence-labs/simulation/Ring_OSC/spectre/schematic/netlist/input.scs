// Design: ee115c/Ring_OSC
simulator lang=spectre
global 0 vdd!
include "/usr/public.2/ee115c/cadence-labs/gpdk090_v3.4/models/spectre/gpdk090.scs" section=NN

// ee115c/INVX1/schematic
subckt INVX1 A GND VDD Z
    NM0 (Z A GND GND) gpdk090_nmos1v w=(240n) l=100n m=(1)*(1) simM=(1)*(1)
    PM0 (Z A VDD VDD) gpdk090_pmos1v w=(480n) l=100n m=(1)*(1) simM=(1)*(1)
ends INVX1

// ee115c/Ring_OSC/schematic
I14 (net8 0 vdd! net5) INVX1
I13 (net9 0 vdd! net8) INVX1
I12 (net10 0 vdd! net9) INVX1
I11 (net11 0 vdd! net10) INVX1
I10 (net12 0 vdd! net11) INVX1
I9 (TP 0 vdd! net16) INVX1
I8 (net16 0 vdd! net15) INVX1
I7 (net15 0 vdd! net14) INVX1
I6 (net14 0 vdd! net13) INVX1
I5 (net13 0 vdd! net12) INVX1
I4 (net17 0 vdd! TP) INVX1
I3 (net19 0 vdd! net17) INVX1
I2 (net18 0 vdd! net19) INVX1
I1 (net20 0 vdd! net18) INVX1
I0 (net5 0 vdd! net20) INVX1
include "./_graphical_stimuli.scs"
simulatorOptions options temp=27
tran tran stop=1.5n errpreset=moderate
