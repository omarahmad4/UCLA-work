// Design: ee115c/HW3_inverters
simulator lang=spectre
global 0
parameters VDD=1 VIN=0
include "/usr/public.2/ee115c/cadence-labs/gpdk090_v3.4/models/spectre/gpdk090.scs" section=NN

// ee115c/HW3_inverters/schematic
NM1 (net6 net10 net11 net11) gpdk090_nmos1v w=(480n) l=100n m=(1)*(1) simM=(1)*(1)
NM0 (net4 net8 net11 net11) gpdk090_nmos1v w=(480n) l=100n m=(1)*(1) simM=(1)*(1)
PM1 (net6 net11 net7 net7) gpdk090_pmos1v w=(240n) l=100n m=(1)*(1) simM=(1)*(1)
PM0 (net4 net8 net9 net9) gpdk090_pmos1v w=(240n) l=100n m=(1)*(1) simM=(1)*(1)
V5 (net11 net6) vsource dc=0 type=dc
V4 (net11 net4) vsource dc=0 type=dc
V3 (net9 net11) vsource dc=VDD type=dc
V2 (net7 net11) vsource dc=VDD type=dc
V1 (net10 net11) vsource dc=VIN type=dc
V0 (net8 net11) vsource dc=VIN type=dc
simulatorOptions options temp=27
dc dc param=VIN start=0 stop=1 step=0.05
save V4:p V5:p
