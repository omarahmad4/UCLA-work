// Design: ee115c/hw3_#1_mirrorAdder_test
simulator lang=spectre
global 0 vdd!
parameters V_A=1 V_B=1 V_Cin=1
include "/usr/public.2/ee115c/cadence-labs/gpdk090_v3.4/models/spectre/gpdk090.scs" section=NN

// ee115c/hw3_#1/schematic
subckt _sub4 A B Cin Cout S
    NM13 (S net41 0 0) gpdk090_nmos1v w=(390n) l=100n m=(1)*(1) simM=(1)*(1)
    NM12 (net52 Cin 0 0) gpdk090_nmos1v w=(720n) l=100n m=(1)*(1) simM=(1)*(1)
    NM11 (net51 B net52 net52) gpdk090_nmos1v w=(720n) l=100n m=(1)*(1) simM=(1)*(1)
    NM10 (net41 A net51 net51) gpdk090_nmos1v w=(720n) l=100n m=(1)*(1) simM=(1)*(1)
    NM9 (net32 Cin 0 0) gpdk090_nmos1v w=(480n) l=100n m=(1)*(1) simM=(1)*(1)
    NM8 (net32 A 0 0) gpdk090_nmos1v w=(480n) l=100n m=(1)*(1) simM=(1)*(1)
    NM7 (net32 B 0 0) gpdk090_nmos1v w=(480n) l=100n m=(1)*(1) simM=(1)*(1)
    NM6 (net41 net22 net32 net32) gpdk090_nmos1v w=(480n) l=100n m=(1)*(1) simM=(1)*(1)
    NM5 (0 net22 Cout Cout) gpdk090_nmos1v w=(230n) l=100n m=(1)*(1) simM=(1)*(1)
    NM4 (net22 A net21 net21) gpdk090_nmos1v w=(480n) l=100n m=(1)*(1) simM=(1)*(1)
    NM3 (net22 Cin net11 net11) gpdk090_nmos1v w=(480n) l=100n m=(1)*(1) simM=(1)*(1)
    NM2 (net21 B 0 0) gpdk090_nmos1v w=(480n) l=100n m=(1)*(1) simM=(1)*(1)
    NM1 (net11 B 0 0) gpdk090_nmos1v w=(480n) l=100n m=(1)*(1) simM=(1)*(1)
    NM0 (net11 A 0 0) gpdk090_nmos1v w=(480n) l=100n m=(1)*(1) simM=(1)*(1)
    PM13 (S net41 vdd! vdd!) gpdk090_pmos1v w=(785n) l=100n m=(1)*(1) simM=(1)*(1)
    PM12 (net49 A vdd! vdd!) gpdk090_pmos1v w=(1.44u) l=100n m=(1)*(1) simM=(1)*(1)
    PM11 (net50 B net49 net49) gpdk090_pmos1v w=(1.44u) l=100n m=(1)*(1) simM=(1)*(1)
    PM10 (net41 Cin net50 net50) gpdk090_pmos1v w=(1.44u) l=100n m=(1)*(1) simM=(1)*(1)
    PM9 (net36 A vdd! vdd!) gpdk090_pmos1v w=(960n) l=100n m=(1)*(1) simM=(1)*(1)
    PM8 (net36 Cin vdd! vdd!) gpdk090_pmos1v w=(960n) l=100n m=(1)*(1) simM=(1)*(1)
    PM7 (net36 B vdd! vdd!) gpdk090_pmos1v w=(960n) l=100n m=(1)*(1) simM=(1)*(1)
    PM6 (net41 net22 net36 net36) gpdk090_pmos1v w=(960n) l=100n m=(1)*(1) simM=(1)*(1)
    PM5 (vdd! net22 Cout Cout) gpdk090_pmos1v w=(460n) l=100n m=(1)*(1) simM=(1)*(1)
    PM4 (net24 B vdd! vdd!) gpdk090_pmos1v w=(960n) l=100n m=(1)*(1) simM=(1)*(1)
    PM3 (net15 B vdd! vdd!) gpdk090_pmos1v w=(960n) l=100n m=(1)*(1) simM=(1)*(1)
    PM2 (net15 A vdd! vdd!) gpdk090_pmos1v w=(960n) l=100n m=(1)*(1) simM=(1)*(1)
    PM1 (net22 A net24 net24) gpdk090_pmos1v w=(960n) l=100n m=(1)*(1) simM=(1)*(1)
    PM0 (net22 Cin net15 net15) gpdk090_pmos1v w=(960n) l=100n m=(1)*(1) simM=(1)*(1)
ends _sub4

// ee115c/hw3_#1_mirrorAdder_test/schematic
I0 (net2 net3 net4 net5 net6) _sub4
V4 (0 net6) vsource type=dc
V3 (0 net5) vsource type=dc
V2 (net4 0) vsource dc=V_Cin type=dc
V1 (net3 0) vsource dc=V_B type=dc
V0 (net2 0) vsource dc=V_A type=dc
simulatorOptions options temp=27
dc dc param=V_Cin start=0 stop=1 lin=1
save I0:4 I0:5
