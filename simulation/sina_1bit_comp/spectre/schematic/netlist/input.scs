// Design: Proj/sina_1bit_comp
simulator lang=spectre
global 0
include "/usr/public.2/ee115c/cadence-labs/gpdk090_v3.4/models/spectre/gpdk090.scs" section=NN

// gsclib090/AND2X1/schematic
subckt AND2X1 A B Y inh_VDD inh_VSS
    mp1 (n0 B inh_VDD inh_VDD) gpdk090_pmos1v w=(360n) l=100n m=(1)*(1) simM=(1)*(1)
    mp0 (n0 A inh_VDD inh_VDD) gpdk090_pmos1v w=(360n) l=100n m=(1)*(1) simM=(1)*(1)
    mp2 (Y n0 inh_VDD inh_VDD) gpdk090_pmos1v w=(650n) l=100n m=(1)*(1) simM=(1)*(1)
    mn2 (Y n0 inh_VSS inh_VSS) gpdk090_nmos1v w=(430n) l=100n m=(1)*(1) simM=(1)*(1)
    mn0 (net127 B inh_VSS inh_VSS) gpdk090_nmos1v w=(240n) l=100n m=(1)*(1) simM=(1)*(1)
    mn1 (n0 A net127 inh_VSS) gpdk090_nmos1v w=(240n) l=100n m=(1)*(1) simM=(1)*(1)
ends AND2X1

// gsclib090/INVX1/schematic
subckt INVX1 A Y inh_VDD inh_VSS
    mp0 (Y A inh_VDD inh_VDD) gpdk090_pmos1v w=(650n) l=100n m=(1)*(1) simM=(1)*(1)
    mn0 (Y A inh_VSS inh_VSS) gpdk090_nmos1v w=(430n) l=100n m=(1)*(1) simM=(1)*(1)
ends INVX1

// gsclib090/NOR2X1/schematic
subckt NOR2X1 A B Y inh_VDD inh_VSS
    mp1 (Y B net41 inh_VDD) gpdk090_pmos1v w=(650n) l=100n m=(1)*(1) simM=(1)*(1)
    mp0 (net41 A inh_VDD inh_VDD) gpdk090_pmos1v w=(650n) l=100n m=(1)*(1) simM=(1)*(1)
    mn1 (Y B inh_VSS inh_VSS) gpdk090_nmos1v w=(430n) l=100n m=(1)*(1) simM=(1)*(1)
    mn0 (Y A inh_VSS inh_VSS) gpdk090_nmos1v w=(430n) l=100n m=(1)*(1) simM=(1)*(1)
ends NOR2X1

// Proj/sina_1bit_comp/schematic
I7 (net9 B net10 VDD GND) AND2X1
I8 (A net8 Q2 VDD GND) AND2X1
I0 (A net9 VDD GND) INVX1
I1 (B net8 VDD GND) INVX1
I14 (net10 Q2 Q1 VDD GND) NOR2X1
include "./_graphical_stimuli.scs"
simulatorOptions options temp=27
tran tran stop=10n
